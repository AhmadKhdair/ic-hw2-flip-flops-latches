*** SPICE deck for cell rise_ff_1230500{sch} from library AhmadKhdairHW2
*** Created on Sun Jun 14, 2026 15:31:44
*** Last revised on Sat Jun 20, 2026 00:26:36
*** Written on Sat Jun 20, 2026 12:03:33 by Electric VLSI Design System, version 9.07
*** Layout tech: mocmos, foundry MOSIS
*** UC SPICE *** , MIN_RESIST 4.0, MIN_CAPAC 0.1FF

.global gnd vdd

*** TOP LEVEL CELL: rise_ff_1230500{sch}
Mnmos@0 net@23 clk gnd gnd NMOS L=0.4U W=2U
Mnmos@1 net@223 din gnd gnd NMOS L=0.4U W=2U
Mnmos@2 net@223 net@23 net@46 gnd NMOS L=0.4U W=2U
Mnmos@3 net@301 clk gnd gnd NMOS L=0.4U W=4U
Mnmos@4 net@46 net@48 net@301 gnd NMOS L=0.4U W=4U
Mnmos@10 net@48 net@46 gnd gnd NMOS L=0.4U W=2U
Mnmos@11 net@177 net@46 gnd gnd NMOS L=0.4U W=2U
Mnmos@12 net@149 clk gnd gnd NMOS L=0.4U W=2U
Mnmos@13 net@338 net@177 gnd gnd NMOS L=0.4U W=2U
Mnmos@14 net@338 clk net@158 gnd NMOS L=0.4U W=2U
Mnmos@15 net@280 net@149 gnd gnd NMOS L=0.4U W=4U
Mnmos@16 net@158 net@160 net@280 gnd NMOS L=0.4U W=4U
Mnmos@17 net@160 net@158 gnd gnd NMOS L=0.4U W=2U
Mnmos@18 dout net@158 gnd gnd NMOS L=0.4U W=2U
Mpmos@0 vdd clk net@23 vdd PMOS L=0.4U W=3U
Mpmos@1 vdd din net@223 vdd PMOS L=0.4U W=3U
Mpmos@2 net@46 clk net@223 vdd PMOS L=0.4U W=3U
Mpmos@3 net@45 net@48 net@46 vdd PMOS L=0.4U W=6U
Mpmos@4 vdd net@23 net@45 vdd PMOS L=0.4U W=6U
Mpmos@10 vdd net@46 net@48 vdd PMOS L=0.4U W=3U
Mpmos@11 vdd net@46 net@177 vdd PMOS L=0.4U W=3U
Mpmos@12 vdd clk net@149 vdd PMOS L=0.4U W=3U
Mpmos@13 vdd net@177 net@338 vdd PMOS L=0.4U W=3U
Mpmos@14 net@158 net@149 net@338 vdd PMOS L=0.4U W=3U
Mpmos@15 net@157 net@160 net@158 vdd PMOS L=0.4U W=6U
Mpmos@16 vdd clk net@157 vdd PMOS L=0.4U W=6U
Mpmos@17 vdd net@158 net@160 vdd PMOS L=0.4U W=3U
Mpmos@18 vdd net@158 dout vdd PMOS L=0.4U W=3U

* Spice Code nodes in cell cell 'rise_ff_1230500{sch}'
VDD vdd 0 DC 5
Vclk clk 0 PULSE(0 5 0n 1n 1n 40n 80n)
Vdata din 0 PULSE(0 5 20n 1n 1n 80n 160n)
Cload dout 0 25fF
.tran 200n
.measure tran clk_to_q_rise TRIG v(clk) VAL=2.5 RISE=2 TARG v(dout) VAL=2.5 RISE=1
.measure tran clk_to_q_fall TRIG v(clk) VAL=2.5 RISE=3 TARG v(dout) VAL=2.5 FALL=1
.include C:\Users\HP\Desktop\Tools\C5_models.txt
.END
