*** SPICE deck for cell latch_1230500{sch} from library AhmadKhdairHW2
*** Created on Sun Jun 14, 2026 13:00:26
*** Last revised on Sat Jun 20, 2026 00:28:02
*** Written on Sat Jun 20, 2026 12:05:52 by Electric VLSI Design System, version 9.07
*** Layout tech: mocmos, foundry MOSIS
*** UC SPICE *** , MIN_RESIST 4.0, MIN_CAPAC 0.1FF

.global gnd vdd

*** TOP LEVEL CELL: latch_1230500{sch}
Mnmos@0 net@9 clk gnd gnd NMOS L=0.4U W=2U
Mnmos@1 net@24 data gnd gnd NMOS L=0.4U W=2U
Mnmos@2 net@24 net@9 net@27 gnd NMOS L=0.4U W=2U
Mnmos@3 net@27 net@52 net@84 gnd NMOS L=0.4U W=4U
Mnmos@4 net@84 clk gnd gnd NMOS L=0.4U W=4U
Mnmos@5 net@52 net@27 gnd gnd NMOS L=0.4U W=2U
Mnmos@6 data_out net@27 gnd gnd NMOS L=0.4U W=2U
Mpmos@0 vdd clk net@9 vdd PMOS L=0.4U W=3U
Mpmos@1 vdd data net@24 vdd PMOS L=0.4U W=3U
Mpmos@2 net@27 clk net@24 vdd PMOS L=0.4U W=3U
Mpmos@3 net@89 net@52 net@27 vdd PMOS L=0.4U W=6U
Mpmos@4 vdd net@9 net@89 vdd PMOS L=0.4U W=6U
Mpmos@5 vdd net@27 net@52 vdd PMOS L=0.4U W=3U
Mpmos@6 vdd net@27 data_out vdd PMOS L=0.4U W=3U

* Spice Code nodes in cell cell 'latch_1230500{sch}'
VDD vdd 0 DC 5
Vclk CLK 0 PULSE(0 5 0 1n 1n 40n 80n)
Vdata data 0 PULSE(0 5 10n 1n 1n 60n 120n)
Cload out 0 25fF
.tran 200n
.measure tran clk_delay TRIG v(CLK) VAL=2.5 RISE=1
.measure tran data_delay TRIG v(data) VAL=2.5 RISE=1
.measure tran out_delay TRIG v(out) VAL=2.5 RISE=1
.include C:\Users\HP\Desktop\Tools\C5_models.txt
.END
